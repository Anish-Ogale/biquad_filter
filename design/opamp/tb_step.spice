* SPDX-License-Identifier: Apache-2.0
* Closed-loop step-settling and noise testbench for the two-stage op-amp
* (design/opamp/opamp_2stage.spice).
*
* Resistive-feedback differential amplifier as a continuous-time stand-in for
* the SC integrator load (pre-layout; the switched-cap version is planned).
* DC closed-loop gain = -Rr/Rin = -0.5, feedback factor beta = Rr/(Rr+Rin) = 1/3
* of the loop, 200 mV differential input step, CL = 5 pF per side.
* tb_ac measures the op-amp alone; this deck checks the same amp settling in a
* closed loop and the integrated differential output noise (10 Hz - 100 kHz).
*
* TEMPLATE: run_corners.sh substitutes __PDK_LIB__, __CORNER__, __TEMP__,
* __VDDA__ and __DAT__ before running ngspice.
.lib __PDK_LIB__ __CORNER__
.temp __TEMP__
.include opamp_2stage.spice

vd vdda 0 __VDDA__
iref pbias 0 DC 60u
xM9 pbias pbias vdda vdda sky130_fd_pr__pfet_g5v0d10v5 w=20 l=0.5 nf=1
x1 vinp vinn outp outn vdda 0 pbias opamp_2stage

* input step: -100 mV on one input, other at VCM -> 200 mV diff drive
Vstep vstp 0 DC 1.65 PWL(0 1.65 1n 1.65 1.1n 1.55) AC 0.1
Vref  vinr 0 DC 1.65
Rinp vstp vinp 400k
Rinn vinr vinn 400k
Rf1  outn vinp 200k
Rf2  outp vinn 200k
CLp  outp 0 5p
CLn  outn 0 5p

.control
tran 1n 1u 1n
let vod = v(outp) - v(outn)
wrdata __DAT__ vod
noise v(outp,outn) Vstep dec 10 10 100k
print inoise_total onoise_total
.endc
.end
